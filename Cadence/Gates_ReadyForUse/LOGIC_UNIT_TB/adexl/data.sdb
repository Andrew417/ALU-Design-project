ADE simulation setup
Run mode: Single Run, Sweeps and Corners
Tests:
  Gates_ReadyForUse:LOGIC_UNIT_TB:1: Gates_ReadyForUse/LOGIC_UNIT_TB/schematic, simulator spectre
Global variables:
  S0 = 1.2
  S1 = 1.2
  S2 = 1.2
