ADE simulation setup
Run mode: Single Run, Sweeps and Corners
Tests:
  Gates_ReadyForUse:LOGIC_UNIT4_TB:1: Gates_ReadyForUse/LOGIC_UNIT4_TB/schematic, simulator spectre
Global variables (all switched off):
  S0 = 1.2
  S1 = 0
  S2 = 1.2
