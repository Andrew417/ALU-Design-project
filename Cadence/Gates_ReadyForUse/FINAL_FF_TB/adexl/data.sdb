ADE simulation setup
Run mode: Single Run, Sweeps and Corners
Tests:
  Gates_ReadyForUse:FINAL_FF_TB:1: Gates_ReadyForUse/FINAL_FF_TB/schematic, simulator spectre
